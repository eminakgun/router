addrmap router_regs {
    // Channel Enable Register
    reg {
        field {
            sw = rw;
            hw = r;
        } ch0_en[2] = 0; // Channel 0 enable
        field {
            sw = rw;
            hw = r;
        } ch1_en[2] = 1; // Channel 1 enable
        field {
            sw = rw;
            hw = r;
        } ch2_en[2] = 2; // Channel 2 enable
        field {
            sw = rw;
            hw = r;
        } ch3_en[2] = 3; // Channel 3 enable
    } CHANNEL_ENABLE @0x00;

    // Mode Register
    reg {
        field {
            sw = rw;
            hw = r;
        } mode[1:0] = 0; // 2-bit mode field
    } MODE @0x04;

    // Priority Register
    reg {
        field {
            sw = rw;
            hw = r;
        } ch0_priority[1:0] = 0; // Priority for channel 0
        field {
            sw = rw;
            hw = r;
        } ch1_priority[3:2] = 0; // Priority for channel 1
        field {
            sw = rw;
            hw = r;
        } ch2_priority[5:4] = 0; // Priority for channel 2
        field {
            sw = rw;
            hw = r;
        } ch3_priority[7:6] = 0; // Priority for channel 3
    } PRIORITY @0x08;

    // Packet Count Register
    reg {
        field {
            sw = r;
            hw = rw;
        } ch0_count[8] = 0;   // Packet count for channel 0
        field {
            sw = r;
            hw = rw;
        } ch1_count[8] = 8;   // Packet count for channel 1
        field {
            sw = r;
            hw = rw;
        } ch2_count[8] = 16;  // Packet count for channel 2
        field {
            sw = r;
            hw = rw;
        } ch3_count[8] = 24;  // Packet count for channel 3
    } PACKET_COUNT @0x0C;
};